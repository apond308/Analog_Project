// Design: MyOwnECE6720/HW10
simulator lang=spectre
global 0
parameters Vds=1.8 Vgs=0
include "/home/AMSICtools/models/Generic180nm.mod"

// MyOwnECE6720/HW10/schematic
M0 (net3 net1 0 0) nmos180 w=10u l=0.18u
V1 (net4 0) vsource dc=Vds type=dc
V0 (net1 0) vsource dc=Vgs type=dc
IPRB0 (net4 net3) iprobe
simulatorOptions options temp=27
dcOp dc
dc dc param=Vgs start=0 stop=1.8 step=0.2
save IPRB0:in
saveOptions options currents=all
