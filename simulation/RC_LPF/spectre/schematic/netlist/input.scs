// Design: MyOwnECE6720/RC_LPF
simulator lang=spectre
global 0
parameters vdc=1
include "/home/AMSICtools/models/Generic180nm.mod"

// MyOwnECE6720/RC_LPF/schematic
R0 (in out) resistor r=1K
C0 (out 0) capacitor c=1p
V0 (in 0) vsource dc=vdc mag=1 type=dc
simulatorOptions options temp=27
ac ac start=1 stop=100G dec=50
