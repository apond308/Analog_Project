// Design: ECE6720/example_cs
simulator lang=spectre
global 0 vdd!
include "/home/AMSICtools/models/Generic180nm.mod"

// ECE6720/example_cs/schematic
VDD (vdd! 0) vsource dc=1.8 type=dc
RL (vdd! out) resistor r=2K
VIN (in 0) vsource dc=680m mag=1 phase=0 type=sine sinedc=680m ampl=100m sinephase=0 freq=1K fundname="fund"
CL (out 0) capacitor c=1p
M1 (out in 0 0) nmos180 w=10u l=0.18u
simulatorOptions options temp=27
ac ac start=10e3 stop=1e9
dcOp dc
dc dc dev=VIN param=dc start=0 stop=1.8
save M1:cgd M1:cgs M1:cgb M1:cdb
